module rdac (out, sel, vdd, vss);
    electrical out;
    input [SEL_BITS:0] sel;
    electrical vdd, vss;
    parameter integer SEL_BITS = 8 from (0:inf);

    analog begin
        V(out) <+ (V(vdd) - V(vss)) * sel / (2 ^ SEL_BITS) + V(vss);
    end
endmodule
