// ****************************************************************
// AMS simulation control file for xrun netlist based flow
// ****************************************************************
simulator lang=spectre

global 0 vdd!

amsd {
    ie vsup=0.75 tr=20p tf=20p rout=0
}

* tran tran stop=1u noisefmax=64G noiseseed=32 annotate=status
// to disable noise, comment the above line and uncomment the line below
tran tran stop=1u annotate=status
